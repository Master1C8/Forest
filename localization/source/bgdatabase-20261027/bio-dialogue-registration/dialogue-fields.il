TYPE TheForestOfLove.Narrative.Dialogue BASE System.Object
FIELD System.String TheForestOfLove.Narrative.Dialogue::dbName
FIELD TheForestOfLove.DB.Dialogue TheForestOfLove.Narrative.Dialogue::dbDialogue
FIELD System.Int32 TheForestOfLove.Narrative.Dialogue::dbDialogueIndex
FIELD System.String TheForestOfLove.Narrative.Dialogue::savekey
FIELD System.String TheForestOfLove.Narrative.Dialogue::pluginDbName
FIELD PixelCrushers.DialogueSystem.Conversation TheForestOfLove.Narrative.Dialogue::pluginDbConversation
FIELD TheForestOfLove.Narrative.DialogueType TheForestOfLove.Narrative.Dialogue::dialogueType
FIELD System.String TheForestOfLove.Narrative.Dialogue::primaryActorDbName
FIELD TheForestOfLove.Narrative.Actor TheForestOfLove.Narrative.Dialogue::primaryActor
FIELD System.String TheForestOfLove.Narrative.Dialogue::initialActorDbName
FIELD TheForestOfLove.Narrative.Actor TheForestOfLove.Narrative.Dialogue::initialActor
FIELD TheForestOfLove.Narrative.Quest TheForestOfLove.Narrative.Dialogue::quest
FIELD System.Int32 TheForestOfLove.Narrative.Dialogue::priority
FIELD System.Boolean TheForestOfLove.Narrative.Dialogue::hasPlayerInitiatedQuestion
FIELD TheForestOfLove.Narrative.Arc TheForestOfLove.Narrative.Dialogue::playerInitiatedQuestion
FIELD System.String TheForestOfLove.Narrative.Dialogue::legacyDatePrefabName
FIELD System.Collections.Generic.List`1<TheForestOfLove.Narrative.Actor> TheForestOfLove.Narrative.Dialogue::dateActors
FIELD System.Collections.Generic.List`1<TheForestOfLove.Narrative.Tag> TheForestOfLove.Narrative.Dialogue::relatedTags
FIELD System.Collections.Generic.List`1<TheForestOfLove.Narrative.Tag> TheForestOfLove.Narrative.Dialogue::tagsAnyInformationalOnly
FIELD System.Collections.Generic.List`1<TheForestOfLove.Narrative.Tag> TheForestOfLove.Narrative.Dialogue::tagsAllInformationalOnly
FIELD System.Boolean TheForestOfLove.Narrative.Dialogue::isBlockedByAntitags
FIELD System.Boolean TheForestOfLove.Narrative.Dialogue::completeStepIfSkippingAnyArc
FIELD TheForestOfLove.InteractionUiStatusIconProfileType TheForestOfLove.Narrative.Dialogue::interactionUiStatusIconProfileType
FIELD System.Boolean TheForestOfLove.Narrative.Dialogue::isFirstDialogueInQuest
FIELD System.Boolean TheForestOfLove.Narrative.Dialogue::isLastDialogueInQuest
FIELD TheForestOfLove.Narrative.DialogueStatusRecord TheForestOfLove.Narrative.Dialogue::statusRecord
FIELD System.Collections.Generic.List`1<TheForestOfLove.Narrative.Arc> TheForestOfLove.Narrative.Dialogue::arcs
FIELD System.Collections.Generic.Dictionary`2<System.String,TheForestOfLove.Narrative.Arc> TheForestOfLove.Narrative.Dialogue::arcsByDbArcSuffix
FIELD System.Collections.Generic.Dictionary`2<System.String,TheForestOfLove.Narrative.Arc> TheForestOfLove.Narrative.Dialogue::arcsBySavekey
FIELD System.Collections.Generic.HashSet`1<System.String> TheForestOfLove.Narrative.Dialogue::arcSuffixesDisallowSkip
FIELD System.Collections.Generic.List`1<TheForestOfLove.Narrative.Arc> TheForestOfLove.Narrative.Dialogue::primaryArcs
FIELD System.Collections.Generic.List`1<TheForestOfLove.Narrative.Arc> TheForestOfLove.Narrative.Dialogue::secondaryArcs
FIELD System.Collections.Generic.List`1<TheForestOfLove.Narrative.Arc> TheForestOfLove.Narrative.Dialogue::idleArcs
FIELD System.Collections.Generic.List`1<TheForestOfLove.Narrative.Arc> TheForestOfLove.Narrative.Dialogue::namedArcs
FIELD System.Collections.Generic.List`1<TheForestOfLove.Narrative.DialoguePreconditions.DialoguePrecondition> TheForestOfLove.Narrative.Dialogue::preconditions
FIELD System.Collections.Generic.List`1<TheForestOfLove.Narrative.DialogueTriggers.DialogueTrigger> TheForestOfLove.Narrative.Dialogue::dialogueTriggers
FIELD System.Collections.Generic.List`1<TheForestOfLove.Narrative.ArcTriggers.ArcTrigger> TheForestOfLove.Narrative.Dialogue::arcTriggers
FIELD System.Collections.Generic.List`1<TheForestOfLove.Narrative.Trigger> TheForestOfLove.Narrative.Dialogue::triggersSkipDuringDialogueSkip
FIELD System.Collections.Generic.List`1<TheForestOfLove.Narrative.Trigger> TheForestOfLove.Narrative.Dialogue::triggersSkipDuringChapterSelect
FIELD System.Collections.Generic.List`1<TheForestOfLove.Narrative.Trigger> TheForestOfLove.Narrative.Dialogue::triggersSkipDuringCheatCode
FIELD System.Collections.Generic.List`1<System.String> TheForestOfLove.Narrative.Dialogue::triggersRequireAny_bugfix
FIELD System.Collections.Generic.List`1<System.String> TheForestOfLove.Narrative.Dialogue::triggersRequireAll_bugfix
PROPERTY System.Boolean TheForestOfLove.Narrative.Dialogue::isPreconditionSatisfied()
PROPERTY TheForestOfLove.Narrative.DialogueStatus TheForestOfLove.Narrative.Dialogue::status()
PROPERTY System.Boolean TheForestOfLove.Narrative.Dialogue::isStarted()
PROPERTY System.Boolean TheForestOfLove.Narrative.Dialogue::isCompleted()
PROPERTY System.Boolean TheForestOfLove.Narrative.Dialogue::isInvalidated()
PROPERTY System.Boolean TheForestOfLove.Narrative.Dialogue::hasPrimaryArcs()
PROPERTY System.Boolean TheForestOfLove.Narrative.Dialogue::hasSecondaryArcs()
PROPERTY System.Boolean TheForestOfLove.Narrative.Dialogue::hasIdleArcs()
PROPERTY System.Boolean TheForestOfLove.Narrative.Dialogue::hasNamedArcs()
PROPERTY System.Boolean TheForestOfLove.Narrative.Dialogue::firstPrimaryArcPlayed()
PROPERTY System.Boolean TheForestOfLove.Narrative.Dialogue::allPrimaryArcsPlayed()
PROPERTY System.Boolean TheForestOfLove.Narrative.Dialogue::allSecondaryArcsPlayed()
